`include "constants.vams"
`include "disciplines.vams"

module Array(WLl, WLr, BLl, BLr,SL, AVSS );
output [6:0] SL;
electrical [6:0] SL;
input [7:0] BLl;
electrical [7:0] BLl;
input [7:0] BLr;
electrical [7:0] BLr;
input [6:0] WLl;
electrical [6:0] WLl;
input [6:0] WLr;
electrical [6:0] WLr;
inout AVSS;
electrical AVSS;

parameter real Rl_0_0 = 10000.0,  Rr_0_1 = 100000.0;
parameter real Rl_0_2 = 100000.0,  Rr_0_3 = 100000.0;
parameter real Rl_0_4 = 100000.0,  Rr_0_5 = 100000.0;
parameter real Rl_0_6 = 100000.0,  Rr_0_7 = 100000.0;
parameter real Rl_0_8 = 100000.0,  Rr_0_9 = 100000.0;
parameter real Rl_0_10 = 100000.0,  Rr_0_11 = 10000.0;
parameter real Rl_0_12 = 100000.0,  Rr_0_13 = 10000.0;
parameter real Rl_0_14 = 100000.0,  Rr_0_15 = 10000.0;
parameter real Rl_1_0 = 100000.0,  Rr_1_1 = 100000.0;
parameter real Rl_1_2 = 100000.0,  Rr_1_3 = 100000.0;
parameter real Rl_1_4 = 100000.0,  Rr_1_5 = 100000.0;
parameter real Rl_1_6 = 100000.0,  Rr_1_7 = 100000.0;
parameter real Rl_1_8 = 100000.0,  Rr_1_9 = 100000.0;
parameter real Rl_1_10 = 100000.0,  Rr_1_11 = 10000.0;
parameter real Rl_1_12 = 100000.0,  Rr_1_13 = 100000.0;
parameter real Rl_1_14 = 100000.0,  Rr_1_15 = 100000.0;
parameter real Rl_2_0 = 100000.0,  Rr_2_1 = 100000.0;
parameter real Rl_2_2 = 100000.0,  Rr_2_3 = 100000.0;
parameter real Rl_2_4 = 100000.0,  Rr_2_5 = 100000.0;
parameter real Rl_2_6 = 100000.0,  Rr_2_7 = 100000.0;
parameter real Rl_2_8 = 100000.0,  Rr_2_9 = 100000.0;
parameter real Rl_2_10 = 100000.0,  Rr_2_11 = 100000.0;
parameter real Rl_2_12 = 100000.0,  Rr_2_13 = 10000.0;
parameter real Rl_2_14 = 100000.0,  Rr_2_15 = 100000.0;
parameter real Rl_3_0 = 100000.0,  Rr_3_1 = 100000.0;
parameter real Rl_3_2 = 100000.0,  Rr_3_3 = 100000.0;
parameter real Rl_3_4 = 100000.0,  Rr_3_5 = 100000.0;
parameter real Rl_3_6 = 100000.0,  Rr_3_7 = 100000.0;
parameter real Rl_3_8 = 100000.0,  Rr_3_9 = 100000.0;
parameter real Rl_3_10 = 100000.0,  Rr_3_11 = 100000.0;
parameter real Rl_3_12 = 100000.0,  Rr_3_13 = 100000.0;
parameter real Rl_3_14 = 100000.0,  Rr_3_15 = 10000.0;
parameter real Rl_4_0 = 25000.0,  Rr_4_1 = 100000.0;
parameter real Rl_4_2 = 100000.0,  Rr_4_3 = 10000.0;
parameter real Rl_4_4 = 100000.0,  Rr_4_5 = 10000.0;
parameter real Rl_4_6 = 100000.0,  Rr_4_7 = 100000.0;
parameter real Rl_4_8 = 100000.0,  Rr_4_9 = 100000.0;
parameter real Rl_4_10 = 2000.0,  Rr_4_11 = 100000.0;
parameter real Rl_4_12 = 100000.0,  Rr_4_13 = 3333.3333333333335;
parameter real Rl_4_14 = 100000.0,  Rr_4_15 = 100000.0;
parameter real Rl_5_0 = 100000.0,  Rr_5_1 = 100000.0;
parameter real Rl_5_2 = 100000.0,  Rr_5_3 = 10000.0;
parameter real Rl_5_4 = 100000.0,  Rr_5_5 = 100000.0;
parameter real Rl_5_6 = 100000.0,  Rr_5_7 = 10000.0;
parameter real Rl_5_8 = 100000.0,  Rr_5_9 = 100000.0;
parameter real Rl_5_10 = 100000.0,  Rr_5_11 = 3333.3333333333335;
parameter real Rl_5_12 = 1250.0,  Rr_5_13 = 100000.0;
parameter real Rl_5_14 = 100000.0,  Rr_5_15 = 3333.3333333333335;
parameter real Rl_6_0 = 100000.0,  Rr_6_1 = 100000.0;
parameter real Rl_6_2 = 100000.0,  Rr_6_3 = 10000.0;
parameter real Rl_6_4 = 100000.0,  Rr_6_5 = 100000.0;
parameter real Rl_6_6 = 100000.0,  Rr_6_7 = 100000.0;
parameter real Rl_6_8 = 100000.0,  Rr_6_9 = 10000.0;
parameter real Rl_6_10 = 100000.0,  Rr_6_11 = 100000.0;
parameter real Rl_6_12 = 100000.0,  Rr_6_13 = 3333.3333333333335;
parameter real Rl_6_14 = 2500.0,  Rr_6_15 = 100000.0;
RRAM_2T2R #(.Rl(Rl_0_0), .Rr(Rr_0_1)) core_0 (.WLl(WLl[0]), .WLr(WLr[0]), .BLl(BLl[0]), .BLr(BLr[0]), .SL(SL[0]));
RRAM_2T2R #(.Rl(Rl_0_2), .Rr(Rr_0_3)) core_1 (.WLl(WLl[0]), .WLr(WLr[0]), .BLl(BLl[1]), .BLr(BLr[1]), .SL(SL[0]));
RRAM_2T2R #(.Rl(Rl_0_4), .Rr(Rr_0_5)) core_2 (.WLl(WLl[0]), .WLr(WLr[0]), .BLl(BLl[2]), .BLr(BLr[2]), .SL(SL[0]));
RRAM_2T2R #(.Rl(Rl_0_6), .Rr(Rr_0_7)) core_3 (.WLl(WLl[0]), .WLr(WLr[0]), .BLl(BLl[3]), .BLr(BLr[3]), .SL(SL[0]));
RRAM_2T2R #(.Rl(Rl_0_8), .Rr(Rr_0_9)) core_4 (.WLl(WLl[0]), .WLr(WLr[0]), .BLl(BLl[4]), .BLr(BLr[4]), .SL(SL[0]));
RRAM_2T2R #(.Rl(Rl_0_10), .Rr(Rr_0_11)) core_5 (.WLl(WLl[0]), .WLr(WLr[0]), .BLl(BLl[5]), .BLr(BLr[5]), .SL(SL[0]));
RRAM_2T2R #(.Rl(Rl_0_12), .Rr(Rr_0_13)) core_6 (.WLl(WLl[0]), .WLr(WLr[0]), .BLl(BLl[6]), .BLr(BLr[6]), .SL(SL[0]));
RRAM_2T2R #(.Rl(Rl_0_14), .Rr(Rr_0_15)) core_7 (.WLl(WLl[0]), .WLr(WLr[0]), .BLl(BLl[7]), .BLr(BLr[7]), .SL(SL[0]));
RRAM_2T2R #(.Rl(Rl_1_0), .Rr(Rr_1_1)) core_8 (.WLl(WLl[1]), .WLr(WLr[1]), .BLl(BLl[0]), .BLr(BLr[0]), .SL(SL[1]));
RRAM_2T2R #(.Rl(Rl_1_2), .Rr(Rr_1_3)) core_9 (.WLl(WLl[1]), .WLr(WLr[1]), .BLl(BLl[1]), .BLr(BLr[1]), .SL(SL[1]));
RRAM_2T2R #(.Rl(Rl_1_4), .Rr(Rr_1_5)) core_10 (.WLl(WLl[1]), .WLr(WLr[1]), .BLl(BLl[2]), .BLr(BLr[2]), .SL(SL[1]));
RRAM_2T2R #(.Rl(Rl_1_6), .Rr(Rr_1_7)) core_11 (.WLl(WLl[1]), .WLr(WLr[1]), .BLl(BLl[3]), .BLr(BLr[3]), .SL(SL[1]));
RRAM_2T2R #(.Rl(Rl_1_8), .Rr(Rr_1_9)) core_12 (.WLl(WLl[1]), .WLr(WLr[1]), .BLl(BLl[4]), .BLr(BLr[4]), .SL(SL[1]));
RRAM_2T2R #(.Rl(Rl_1_10), .Rr(Rr_1_11)) core_13 (.WLl(WLl[1]), .WLr(WLr[1]), .BLl(BLl[5]), .BLr(BLr[5]), .SL(SL[1]));
RRAM_2T2R #(.Rl(Rl_1_12), .Rr(Rr_1_13)) core_14 (.WLl(WLl[1]), .WLr(WLr[1]), .BLl(BLl[6]), .BLr(BLr[6]), .SL(SL[1]));
RRAM_2T2R #(.Rl(Rl_1_14), .Rr(Rr_1_15)) core_15 (.WLl(WLl[1]), .WLr(WLr[1]), .BLl(BLl[7]), .BLr(BLr[7]), .SL(SL[1]));
RRAM_2T2R #(.Rl(Rl_2_0), .Rr(Rr_2_1)) core_16 (.WLl(WLl[2]), .WLr(WLr[2]), .BLl(BLl[0]), .BLr(BLr[0]), .SL(SL[2]));
RRAM_2T2R #(.Rl(Rl_2_2), .Rr(Rr_2_3)) core_17 (.WLl(WLl[2]), .WLr(WLr[2]), .BLl(BLl[1]), .BLr(BLr[1]), .SL(SL[2]));
RRAM_2T2R #(.Rl(Rl_2_4), .Rr(Rr_2_5)) core_18 (.WLl(WLl[2]), .WLr(WLr[2]), .BLl(BLl[2]), .BLr(BLr[2]), .SL(SL[2]));
RRAM_2T2R #(.Rl(Rl_2_6), .Rr(Rr_2_7)) core_19 (.WLl(WLl[2]), .WLr(WLr[2]), .BLl(BLl[3]), .BLr(BLr[3]), .SL(SL[2]));
RRAM_2T2R #(.Rl(Rl_2_8), .Rr(Rr_2_9)) core_20 (.WLl(WLl[2]), .WLr(WLr[2]), .BLl(BLl[4]), .BLr(BLr[4]), .SL(SL[2]));
RRAM_2T2R #(.Rl(Rl_2_10), .Rr(Rr_2_11)) core_21 (.WLl(WLl[2]), .WLr(WLr[2]), .BLl(BLl[5]), .BLr(BLr[5]), .SL(SL[2]));
RRAM_2T2R #(.Rl(Rl_2_12), .Rr(Rr_2_13)) core_22 (.WLl(WLl[2]), .WLr(WLr[2]), .BLl(BLl[6]), .BLr(BLr[6]), .SL(SL[2]));
RRAM_2T2R #(.Rl(Rl_2_14), .Rr(Rr_2_15)) core_23 (.WLl(WLl[2]), .WLr(WLr[2]), .BLl(BLl[7]), .BLr(BLr[7]), .SL(SL[2]));
RRAM_2T2R #(.Rl(Rl_3_0), .Rr(Rr_3_1)) core_24 (.WLl(WLl[3]), .WLr(WLr[3]), .BLl(BLl[0]), .BLr(BLr[0]), .SL(SL[3]));
RRAM_2T2R #(.Rl(Rl_3_2), .Rr(Rr_3_3)) core_25 (.WLl(WLl[3]), .WLr(WLr[3]), .BLl(BLl[1]), .BLr(BLr[1]), .SL(SL[3]));
RRAM_2T2R #(.Rl(Rl_3_4), .Rr(Rr_3_5)) core_26 (.WLl(WLl[3]), .WLr(WLr[3]), .BLl(BLl[2]), .BLr(BLr[2]), .SL(SL[3]));
RRAM_2T2R #(.Rl(Rl_3_6), .Rr(Rr_3_7)) core_27 (.WLl(WLl[3]), .WLr(WLr[3]), .BLl(BLl[3]), .BLr(BLr[3]), .SL(SL[3]));
RRAM_2T2R #(.Rl(Rl_3_8), .Rr(Rr_3_9)) core_28 (.WLl(WLl[3]), .WLr(WLr[3]), .BLl(BLl[4]), .BLr(BLr[4]), .SL(SL[3]));
RRAM_2T2R #(.Rl(Rl_3_10), .Rr(Rr_3_11)) core_29 (.WLl(WLl[3]), .WLr(WLr[3]), .BLl(BLl[5]), .BLr(BLr[5]), .SL(SL[3]));
RRAM_2T2R #(.Rl(Rl_3_12), .Rr(Rr_3_13)) core_30 (.WLl(WLl[3]), .WLr(WLr[3]), .BLl(BLl[6]), .BLr(BLr[6]), .SL(SL[3]));
RRAM_2T2R #(.Rl(Rl_3_14), .Rr(Rr_3_15)) core_31 (.WLl(WLl[3]), .WLr(WLr[3]), .BLl(BLl[7]), .BLr(BLr[7]), .SL(SL[3]));
RRAM_2T2R #(.Rl(Rl_4_0), .Rr(Rr_4_1)) core_32 (.WLl(WLl[4]), .WLr(WLr[4]), .BLl(BLl[0]), .BLr(BLr[0]), .SL(SL[4]));
RRAM_2T2R #(.Rl(Rl_4_2), .Rr(Rr_4_3)) core_33 (.WLl(WLl[4]), .WLr(WLr[4]), .BLl(BLl[1]), .BLr(BLr[1]), .SL(SL[4]));
RRAM_2T2R #(.Rl(Rl_4_4), .Rr(Rr_4_5)) core_34 (.WLl(WLl[4]), .WLr(WLr[4]), .BLl(BLl[2]), .BLr(BLr[2]), .SL(SL[4]));
RRAM_2T2R #(.Rl(Rl_4_6), .Rr(Rr_4_7)) core_35 (.WLl(WLl[4]), .WLr(WLr[4]), .BLl(BLl[3]), .BLr(BLr[3]), .SL(SL[4]));
RRAM_2T2R #(.Rl(Rl_4_8), .Rr(Rr_4_9)) core_36 (.WLl(WLl[4]), .WLr(WLr[4]), .BLl(BLl[4]), .BLr(BLr[4]), .SL(SL[4]));
RRAM_2T2R #(.Rl(Rl_4_10), .Rr(Rr_4_11)) core_37 (.WLl(WLl[4]), .WLr(WLr[4]), .BLl(BLl[5]), .BLr(BLr[5]), .SL(SL[4]));
RRAM_2T2R #(.Rl(Rl_4_12), .Rr(Rr_4_13)) core_38 (.WLl(WLl[4]), .WLr(WLr[4]), .BLl(BLl[6]), .BLr(BLr[6]), .SL(SL[4]));
RRAM_2T2R #(.Rl(Rl_4_14), .Rr(Rr_4_15)) core_39 (.WLl(WLl[4]), .WLr(WLr[4]), .BLl(BLl[7]), .BLr(BLr[7]), .SL(SL[4]));
RRAM_2T2R #(.Rl(Rl_5_0), .Rr(Rr_5_1)) core_40 (.WLl(WLl[5]), .WLr(WLr[5]), .BLl(BLl[0]), .BLr(BLr[0]), .SL(SL[5]));
RRAM_2T2R #(.Rl(Rl_5_2), .Rr(Rr_5_3)) core_41 (.WLl(WLl[5]), .WLr(WLr[5]), .BLl(BLl[1]), .BLr(BLr[1]), .SL(SL[5]));
RRAM_2T2R #(.Rl(Rl_5_4), .Rr(Rr_5_5)) core_42 (.WLl(WLl[5]), .WLr(WLr[5]), .BLl(BLl[2]), .BLr(BLr[2]), .SL(SL[5]));
RRAM_2T2R #(.Rl(Rl_5_6), .Rr(Rr_5_7)) core_43 (.WLl(WLl[5]), .WLr(WLr[5]), .BLl(BLl[3]), .BLr(BLr[3]), .SL(SL[5]));
RRAM_2T2R #(.Rl(Rl_5_8), .Rr(Rr_5_9)) core_44 (.WLl(WLl[5]), .WLr(WLr[5]), .BLl(BLl[4]), .BLr(BLr[4]), .SL(SL[5]));
RRAM_2T2R #(.Rl(Rl_5_10), .Rr(Rr_5_11)) core_45 (.WLl(WLl[5]), .WLr(WLr[5]), .BLl(BLl[5]), .BLr(BLr[5]), .SL(SL[5]));
RRAM_2T2R #(.Rl(Rl_5_12), .Rr(Rr_5_13)) core_46 (.WLl(WLl[5]), .WLr(WLr[5]), .BLl(BLl[6]), .BLr(BLr[6]), .SL(SL[5]));
RRAM_2T2R #(.Rl(Rl_5_14), .Rr(Rr_5_15)) core_47 (.WLl(WLl[5]), .WLr(WLr[5]), .BLl(BLl[7]), .BLr(BLr[7]), .SL(SL[5]));
RRAM_2T2R #(.Rl(Rl_6_0), .Rr(Rr_6_1)) core_48 (.WLl(WLl[6]), .WLr(WLr[6]), .BLl(BLl[0]), .BLr(BLr[0]), .SL(SL[6]));
RRAM_2T2R #(.Rl(Rl_6_2), .Rr(Rr_6_3)) core_49 (.WLl(WLl[6]), .WLr(WLr[6]), .BLl(BLl[1]), .BLr(BLr[1]), .SL(SL[6]));
RRAM_2T2R #(.Rl(Rl_6_4), .Rr(Rr_6_5)) core_50 (.WLl(WLl[6]), .WLr(WLr[6]), .BLl(BLl[2]), .BLr(BLr[2]), .SL(SL[6]));
RRAM_2T2R #(.Rl(Rl_6_6), .Rr(Rr_6_7)) core_51 (.WLl(WLl[6]), .WLr(WLr[6]), .BLl(BLl[3]), .BLr(BLr[3]), .SL(SL[6]));
RRAM_2T2R #(.Rl(Rl_6_8), .Rr(Rr_6_9)) core_52 (.WLl(WLl[6]), .WLr(WLr[6]), .BLl(BLl[4]), .BLr(BLr[4]), .SL(SL[6]));
RRAM_2T2R #(.Rl(Rl_6_10), .Rr(Rr_6_11)) core_53 (.WLl(WLl[6]), .WLr(WLr[6]), .BLl(BLl[5]), .BLr(BLr[5]), .SL(SL[6]));
RRAM_2T2R #(.Rl(Rl_6_12), .Rr(Rr_6_13)) core_54 (.WLl(WLl[6]), .WLr(WLr[6]), .BLl(BLl[6]), .BLr(BLr[6]), .SL(SL[6]));
RRAM_2T2R #(.Rl(Rl_6_14), .Rr(Rr_6_15)) core_55 (.WLl(WLl[6]), .WLr(WLr[6]), .BLl(BLl[7]), .BLr(BLr[7]), .SL(SL[6]));

endmodule
